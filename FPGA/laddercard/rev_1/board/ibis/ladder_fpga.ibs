[IBIS Ver] 4.1
[File Name] ladder_fpga.ibs
[File Rev] 3.2
[Date] May 29, 2014
[Source] Derived from cycloneIII_spice_model,rev 1.0, dated 11/02/07
   using HSPICE Y-2006.03
[Notes]
|   - The models are designated as "Final" and have been
|   correlated against physical device operation. There
|   will not be any planned changes to be made to the models.
|   - This IBIS model is checked using IBISCHK v4.2.2.
|   There are no known errors and warnings reported.
|   - There are no known limitations for this IBIS
|   model release.
|   - Contact point: Altera Corporation,
|   http://www.altera.com/corporate/contact/con-index.html
|   - This file is generated using
|   Quartus II 64-Bit Version 12.1 Build 177 11/07/2012 SJ Web Edition
|   Revision History
|   - v3.2
|   - Added 50ohm Series On-Chip Termination with Calibration
|   models with PCI-diode enabled IBIS models
|   - v3.1
|   - Added 50ohm Series On-Chip Termination without Calibration
|   models with PCI-diode enabled IBIS models
|   - Added Cref, Vref and Rref subparameters and removed Test_load
|   keyword for all SSTL & DSSTL IBIS models
|   - Added crc_error and init_done configuration pin IBIS models
|   - v3.0
|   - Updated the file revision from version 2.3 to version 3.0
|   to indicate that Cyclone III devices are mature products
|   - v2.3
|   - Added 18 2.5V BLVDS IBIS models for CIO & RDIO across
|   different drive strength and slew rate options
|   - blvds25_cio_d8s   - blvds25_cio_d12s   - blvds25_cio_d16s
|   - blvds25_cio_d8m   - blvds25_cio_d12m   - blvds25_cio_d16m
|   - blvds25_cio_d8f   - blvds25_cio_d12f   - blvds25_cio_d16f
|   - blvds25_rdio_d8s   - blvds25_rdio_d12s   - blvds25_rdio_d16s
|   - blvds25_rdio_d8m   - blvds25_rdio_d12m   - blvds25_rdio_d16m
|   - blvds25_rdio_d8f   - blvds25_rdio_d12f   - blvds25_rdio_d16f
|   - v2.2
|   - Updated Vref and V_term1 value for the following I/O standard:
|   - 1.8V HSTL CI&CII - Vref = 0.83V to Vref = 0.90V
|   - 1.8V DHSTL CI&CII - Vref = 0.83V to Vref = 0.90V
|   - 1.5V HSTL CI&CII - Vref = 0.6875V to Vref = 0.75V
|   - 1.5V DHSTL CI&CII - Vref = 0.6875V to Vref = 0.75V
|   - 1.2V HSTL CI&CII - Vref = 0.55V to Vref = 0.60V
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Unused IOs which have been assigned as tri-stated inputs or
as outputs driving any signal in Quartus II are represented by the NC.
[Disclaimer] Data is for modeling purposes only and is not guaranteed.
[Copyright]
Copyright (C) 1991-2012 Altera Corporation
Your use of Altera Corporation's design tools, logic functions
and other software and tools, and its AMPP partner logic
functions, and any output files from any of the foregoing
(including device programming or simulation files), and any
associated documentation or information are expressly subject
to the terms and conditions of the Altera Program License
Subscription Agreement, Altera MegaCore Function License
Agreement, or other applicable license agreement, including,
without limitation, that your use is for the sole purpose of
programming logic devices manufactured by Altera and sold by
Altera or its authorized distributors.  Please refer to the
applicable agreement for further details.
[Component] EP3C16F484C6_ladder_fpga
[Manufacturer]  Altera Corporation
[Package]
| RLC values are for 484 FBGA package
|variable  typ  min  max
R_pkg  561.00m   255.00m   819.00m
L_pkg  3.97nH   1.90nH   5.87nH
C_pkg  0.83pF   0.61pF   1.45pF
[Pin]  signal_name   model_name   R_pin   L_pin   C_pin
A1   GND   GND
A2   VCCIO8   POWER
A3   card_ser_num[0]   cmos33_cin_p
A4   card_ser_num[1]   cmos33_cin_p
A5   sc_tdo_hybride[0]   cmos33_cin_p
A6   usb_tx_full   cmos33_cin_p
A7   usb_reset_n   cmos33_cio_d2p_ms1
A8   sc_serdes_ou_connec   cmos33_cin_p
A9   data_serial[11]   cmos33_cin_p
A10   sc_tck_hybride[1]   cmos33_cio_d2_ms2
A11   reset_n   cmos33_cin_p
A12   sc_tdo_hybride[3]   cmos33_cin_p
A13   sc_tck_hybride[3]   cmos33_cio_d2_ms2
A14   sc_tck_hybride[2]   cmos33_cio_d2_ms2
A15   ladder_fpga_rclk_16h  cmos33_cio_d2_ms2
A16   tokenout_hybride[6]   cmos33_cin_p
A17   sc_tdi_hybride[9]   cmos33_cio_d2_ms2
A18   sc_tdo_hybride[2]   cmos33_cin_p
A19   sc_tms_hybride[7]   cmos33_cio_d2_ms2
A20   tokenin_hybride[8]   cmos33_cio_d2_ms2
A21   VCCIO7   POWER
A22   GND   GND
AA1   ladder_fpga_sc_tdo   cmos33_rdio_d2_ms3
AA2   pilotage_magnd_hybri  cmos33_rdio_d2p_ms4
AA3   clock80mhz_adc   cmos33_cio_d2_ms2
AA4   pilotage_magnd_hybri  cmos33_cio_d2p_ms1
AA5   rdo_to_ladder[13]   cmos33_cin_p
AA6   VCCIO3   POWER
AA7   pilotage_mvdd_hybrid  cmos33_cio_d2p_ms1
AA8   data_serial[0]   cmos33_cin_p
AA9   data_serial[2]   cmos33_cin_p
AA10   ladder_to_rdo[16]   cmos33_cio_d2_ms2
AA11   testin_echelle   cmos33_cin_p
AA12   tokenout_hybride[15]  cmos33_cin_p
AA13   data_serial[14]   cmos33_cin_p
AA14   tokenin_hybride[15]   cmos33_cio_d2_ms2
AA15   tokenout_hybride[7]   cmos33_cin_p
AA16   pilotage_magnd_hybri  cmos33_cio_d2p_ms1
AA17   tokenout_hybride[9]   cmos33_cin_p
AA18   sc_tms_hybride[9]   cmos33_cio_d2_ms2
AA19   sc_tck_hybride[9]   cmos33_cio_d2_ms2
AA20   pilotage_magnd_hybri  cmos33_cio_d2p_ms1
AA21   usb_data[5]   cmos33_rdin_p
AA22   usb_write   cmos33_rdio_d2_ms3
AB1   GND   GND
AB2   VCCIO3   POWER
AB3   usb_data[1]   cmos33_cin_p
AB4   pilotage_mvdd_hybrid  cmos33_cio_d2p_ms1
AB5   rdo_to_ladder[15]   cmos33_cin_p
AB6   GND   GND
AB7   sc_trstb_hybride[11]  cmos33_cio_d2_ms2
AB8   pilotage_mvdd_hybrid  cmos33_cio_d2p_ms1
AB9   sc_tdi_hybride[5]   cmos33_cio_d2_ms2
AB10   data_serial[12]   cmos33_cin_p
AB11   ladder_fpga_sc_trstb  cmos33_cin_p
AB12   tokenin_echelle   cmos33_cin_p
AB13   data_serial[4]   cmos33_cin_p
AB14   usb_ready_n   cmos33_cin_p
AB15   pilotage_mvdd_hybrid  cmos33_cio_d2p_ms1
AB16   rdo_to_ladder[16]   cmos33_cin_p
AB17   sc_tdi_hybride[7]   cmos33_cio_d2_ms2
AB18   sc_tms_hybride[10]   cmos33_cio_d2_ms2
AB19   pilotage_magnd_hybri  cmos33_cio_d2p_ms1
AB20   pilotage_magnd_hybri  cmos33_cio_d2p_ms1
AB21   VCCIO4   POWER
AB22   GND   GND
B1   roboclock_horloge40_  cmos33_rdio_d2p_ms4
B2   roboclock_horloge40_  cmos33_rdio_d2p_ms4
B3   debug_present_n   cmos33_cin_p
B4   adc_cs_n[0]   cmos33_cio_d2_ms2
B5   adc_cs_n[4]   cmos33_cio_d2_ms2
B6   tokenout_hybride[0]   cmos33_cin_p
B7   adc_cs_n[1]   cmos33_cio_d2_ms2
B8   data_serial[10]   cmos33_cin_p
B9   ladder_to_rdo[0]   cmos33_cio_d2_ms2
B10   fibre_mod_sda   cmos33_cin_p
B11   sc_tdo_hybride[1]   cmos33_cin_p
B12   sc_tdo_hybride[5]   cmos33_cin_p
B13   pilotage_magnd_hybri  cmos33_cio_d2p_ms1
B14   pilotage_magnd_hybri  cmos33_cio_d2p_ms1
B15   pilotage_magnd_hybri  cmos33_cio_d2p_ms1
B16   sc_tms_hybride[8]   cmos33_cio_d2_ms2
B17   mux_ref_latchup[1]   cmos33_cio_d2_ms2
B18   latchup_hybride[6]   cmos33_cin_p
B19   tokenin_hybride[10]   cmos33_cio_d2_ms2
B20   sc_tdo_hybride[10]   cmos33_cin_p
B21   sc_tck_hybride[10]   cmos33_rdio_d2_ms3
B22   sc_trstb_hybride[3]   cmos33_rdio_d2_ms3
C1   roboclock_horloge40_  cmos33_rdio_d2p_ms4
C2   roboclock_horloge40_  cmos33_rdio_d2p_ms4
C3   usb_data[2]   cmos33_cin_p
C4   ladder_to_rdo[21]   cmos33_cio_d2_ms2
C5   GND   GND
C6   sc_tdi_hybride[14]   cmos33_cio_d2_ms2
C7   adc_cs_n[5]   cmos33_cio_d2_ms2
C8   adc_cs_n[6]   cmos33_cio_d2_ms2
C9   GND   GND
C10   fpga_serdes_ou_conne  cmos33_cin_p
C11   GND   GND
C12   GND   GND
C13   sc_tck_hybride[6]   cmos33_cio_d2_ms2
C14   GND   GND
C15   pilotage_magnd_hybri  cmos33_cio_d2p_ms1
C16   GND   GND
C17   sc_tdi_hybride[11]   cmos33_cio_d2_ms2
C18   GND   GND
C19   sc_trstb_hybride[1]   cmos33_cio_d2_ms2
C21   pilotage_mvdd_hybrid  cmos33_rdio_d2p_ms4
C22   sc_tck_hybride[4]   cmos33_rdio_d2_ms3
D1   ~ALTERA_ASDO_DATA1~   3p3_rio_asdo_data1
D2   ladder_to_rdo[20]   cmos33_rdio_d2_ms3
D3   GND   GND
D4   VCCIO1   POWER
D5   VCCIO8   POWER
D6   fibre_rx_loss   cmos33_cin_p
D7   GND   GND
D8   GND   GND
D9   VCCIO8   POWER
D10   tokenin_hybride[0]   cmos33_cio_d2_ms2
D11   VCCIO8   POWER
D12   VCCIO7   POWER
D13   tokenin_hybride[1]   cmos33_cio_d2_ms2
D14   VCCIO7   POWER
D15   pilotage_magnd_hybri  cmos33_cio_d2p_ms1
D16   VCCIO7   POWER
D17   xtal_en   cmos33_cin_p
D18   VCCIO7   POWER
D19   sc_trstb_hybride[2]   cmos33_cio_d2_ms2
D20   sc_tdi_hybride[10]   cmos33_rdio_d2_ms3
D21   sc_tdi_hybride[6]   cmos33_rdio_d2_ms3
D22   sc_tck_hybride[0]   cmos33_rdio_d2_ms3
E1   card_ser_num[2]   cmos33_rdin_p
E2   ~ALTERA_FLASH_nCE_nC  3p3_ro_flsh_nce_ncso
E3   temperature   cmos33_rdio_d2p_ms4
E4   spare_switch   cmos33_rdin_p
E6   ladder_to_rdo[6]   cmos33_cio_d2_ms2
E7   sc_tms_hybride[11]   cmos33_cio_d2_ms2
E8   VCCIO8   POWER
E9   tokenout_hybride[5]   cmos33_cin_p
E10   sc_tms_hybride[15]   cmos33_cio_d2_ms2
E11   data_serial[3]   cmos33_cin_p
E12   tokenout_hybride[8]   cmos33_cin_p
E13   pilotage_mvdd_hybrid  cmos33_cio_d2p_ms1
E15   latchup_hybride[4]   cmos33_cin_p
E16   sc_tck_hybride[7]   cmos33_cio_d2_ms2
E17   VCCD_PLL2   POWER
E18   NC   NC
E19   VCCIO6   POWER
E20   GND   GND
E21   tokenin_hybride[9]   cmos33_rdio_d2_ms3
E22   tokenout_hybride[4]   cmos33_rdin_p
F1   ladder_to_rdo[15]   cmos33_rdio_d2_ms3
F2   ladder_to_rdo[3]   cmos33_rdio_d2_ms3
F3   GND   GND
F4   VCCIO1   POWER
F5   NC   NC
F6   VCCD_PLL3   POWER
F9   tokenin_hybride[5]   cmos33_cio_d2_ms2
F10   tokenout_hybride[1]   cmos33_cin_p
F11   sc_tdi_hybride[1]   cmos33_cio_d2_ms2
F12   sc_trstb_hybride[0]   cmos33_cio_d2_ms2
F13   test_16hybrides   cmos33_cio_d2_ms2
F15   latchup_hybride[9]   cmos33_cin_p
F16   sc_tms_hybride[2]   cmos33_cio_d2_ms2
F17   latchup_hybride[2]   cmos33_rdin_p
F18   VCCA2   POWER
F19   tokenin_hybride[12]   cmos33_rdio_d2_ms3
F20   sc_tck_hybride[8]   cmos33_rdio_d2_ms3
F21   pilotage_magnd_hybri  cmos33_rdio_d2p_ms4
F22   tokenout_hybride[14]  cmos33_rdin_p
G1   clock40mhz_xtal   cmos33_rdin_p
G2   clock40mhz_fpga   cmos33_rdin_p
G3   ladder_fpga_sc_tms   cmos33_rdin_p
G4   fibre_mod_scl   cmos33_rdin_p
G6   VCCA3   POWER
G9   adc_cs_n[3]   cmos33_cio_d2_ms2
G10   adc_cs_n[7]   cmos33_cio_d2_ms2
G11   pilotage_mvdd_hybrid  cmos33_cio_d2p_ms1
G12   dbg_ladder_fpga_sc_b  cmos33_cio_d2_ms2
G13   pilotage_magnd_hybri  cmos33_cio_d2p_ms1
G14   roboclock_adc_phase[  cmos33_cio_d2p_ms1
G15   roboclock_adc_phase[  cmos33_cio_d2p_ms1
G18   sc_tdo_hybride[8]   cmos33_rdin_p
G19   VCCIO6   POWER
G20   GND   GND
G21   sc_tdo_hybride[4]   cmos33_rdin_p
G22   data_serial[7]   cmos33_rdin_p
H1   card_ser_num[3]   cmos33_rdin_p
H2   fibre_tx_fault   cmos33_rdin_p
H3   GND   GND
H4   VCCIO1   POWER
H6   latchup_hybride[10]   cmos33_rdin_p
H7   sc_tck_hybride[13]   cmos33_rio_d2_ms5
H8   GND   GND
H9   adc_cs_n[2]   cmos33_cio_d2_ms2
H10   ladder_to_rdo[14]   cmos33_cio_d2_ms2
H11   latchup_hybride[5]   cmos33_cin_p
H12   tokenin_hybride[2]   cmos33_cio_d2_ms2
H15   sc_tdo_hybride[7]   cmos33_cin_p
H16   sc_tdi_hybride[2]   cmos33_rdio_d2_ms3
H17   tokenin_hybride[6]   cmos33_rdio_d2_ms3
H19   sc_tms_hybride[6]   cmos33_rdio_d2_ms3
H20   sc_trstb_hybride[12]  cmos33_rdio_d2_ms3
H21   sc_tdo_hybride[9]   cmos33_rdin_p
H22   sc_tck_hybride[5]   cmos33_rdio_d2_ms3
J1   ladder_to_rdo[13]   cmos33_rdio_d2_ms3
J2   rdo_to_ladder[10]   cmos33_rdin_p
J3   ladder_to_rdo[11]   cmos33_rio_d2_ms5
J4   ladder_to_rdo[17]   cmos33_rio_d2_ms5
J5   GND   GND
J6   sc_trstb_hybride[15]  cmos33_rdio_d2_ms3
J7   pilotage_mvdd_hybrid  cmos33_rdio_d2p_ms4
J8   VCCINT   POWER
J9   GND   GND
J10   VCCINT   POWER
J11   VCCINT   POWER
J12   VCCINT   POWER
J13   VCCINT   POWER
J14   VCCINT   POWER
J15   tokenin_hybride[3]   cmos33_rio_d2_ms5
J16   sc_tms_hybride[3]   cmos33_rdio_d2_ms3
J17   tokenin_hybride[4]   cmos33_rdio_d2_ms3
J18   tokenin_hybride[7]   cmos33_rio_d2_ms5
J19   GND   GND
J20   VCCIO6   POWER
J21   pilotage_mvdd_hybrid  cmos33_rdio_d2p_ms4
J22   pilotage_mvdd_hybrid  cmos33_rdio_d2p_ms4
K1   ~ALTERA_DATA0~   3p3_rio_data0
K2   ~ALTERA_DCLK~   3p3_rio_dclk
K3   GND   GND
K4   VCCIO1   POWER
K5   nCONFIG   ttl33_rin
K6   nSTATUS   3p3_rio_nstatus
K7   pilotage_mvdd_hybrid  cmos33_rdio_d2p_ms4
K8   pilotage_magnd_hybri  cmos33_rdio_d2p_ms4
K9   VCCINT   POWER
K10   GND   GND
K11   GND   GND
K12   GND   GND
K13   GND   GND
K14   VCCINT   POWER
K15   roboclock_adc_phase[  cmos33_rio_d2p_ms6
K16   sc_tms_hybride[4]   cmos33_rdio_d2_ms3
K17   sc_tdi_hybride[3]   cmos33_rdio_d2_ms3
K18   hold_16hybrides   cmos33_rdio_d2_ms3
K19   roboclock_adc_phase[  cmos33_rio_d2p_ms6
K20   MSEL3   ttl33_rin
K21   latchup_hybride[7]   cmos33_rdin_p
K22   ~ALTERA_nCEO~   3p3_ro_nceo
L1   TMS   ttl33_rin
L2   TCK   ttl33_rin
L3   nCE   ttl33_rin
L4   TDO   3p3_ro_tdo
L5   TDI   ttl33_rin
L6   sc_trstb_hybride[14]  cmos33_rdio_d2_ms3
L7   card_ser_num[4]   cmos33_rin_p
L8   tokenin_hybride[14]   cmos33_rdio_d2_ms3
L9   VCCINT   POWER
L10   GND   GND
L11   GND   GND
L12   GND   GND
L13   GND   GND
L14   VCCINT   POWER
L16   pilotage_magnd_hybri  cmos33_rdio_d2p_ms4
L17   MSEL2   ttl33_rin
L18   MSEL1   ttl33_rin
L19   VCCIO6   POWER
L20   GND   GND
L21   crc_error   cmos33_rdio_d2p_ms4
L22   pilotage_mvdd_hybrid  cmos33_rdio_d2p_ms4
M1   ladder_to_rdo[10]   cmos33_rdio_d2_ms3
M2   data_serial[8]   cmos33_rdin_p
M3   ladder_to_rdo[19]   cmos33_rdio_d2_ms3
M4   sc_tdi_hybride[0]   cmos33_rdio_d2_ms3
M5   ladder_to_rdo[18]   cmos33_rio_d2_ms5
M6   data_serial[1]   cmos33_rdin_p
M7   usb_data[4]   cmos33_rdin_p
M8   ladder_to_rdo[9]   cmos33_rdio_d2_ms3
M9   VCCINT   POWER
M10   GND   GND
M11   GND   GND
M12   GND   GND
M13   GND   GND
M14   VCCINT   POWER
M15   latchup_hybride[13]   cmos33_rdin_p
M16   tokenin_hybride[11]   cmos33_rio_d2_ms5
M17   MSEL0   ttl33_rin
M18   CONF_DONE   3p3_rio_condone
M19   sc_trstb_hybride[6]   cmos33_rdio_d2_ms3
M20   sc_tdi_hybride[4]   cmos33_rdio_d2_ms3
M21   sc_trstb_hybride[9]   cmos33_rdio_d2_ms3
M22   usb_rx_empty   cmos33_rdin_p
N1   ladder_to_rdo[8]   cmos33_rdio_d2_ms3
N2   ladder_to_rdo[5]   cmos33_rdio_d2_ms3
N3   GND   GND
N4   VCCIO2   POWER
N5   data_serial[9]   cmos33_rin_p
N6   tokenout_hybride[3]   cmos33_rdin_p
N8   usb_data[7]   cmos33_rdin_p
N9   VCCINT   POWER
N10   GND   GND
N11   GND   GND
N12   GND   GND
N13   GND   GND
N14   tokenin_hybride[13]   cmos33_rio_d2_ms5
N15   sc_trstb_hybride[8]   cmos33_rdio_d2_ms3
N17   rdo_to_ladder[14]   cmos33_rdin_p
N18   tokenout_hybride[10]  cmos33_rdin_p
N20   sc_tdi_hybride[8]   cmos33_rdio_d2_ms3
N21   tokenout_hybride[2]   cmos33_rdin_p
N22   sc_tdi_hybride[12]   cmos33_rdio_d2_ms3
P1   usb_data[0]   cmos33_rdin_p
P2   ladder_addr[0]   cmos33_rdin_p
P3   rdo_to_ladder[17]   cmos33_rdin_p
P4   rdo_to_ladder[12]   cmos33_rdin_p
P5   sc_tms_hybride[1]   cmos33_rio_d2_ms5
P9   VCCINT   POWER
P10   VCCINT   POWER
P11   VCCINT   POWER
P12   VCCINT   POWER
P13   VCCINT   POWER
P15   sc_tdo_hybride[13]   cmos33_rdin_p
P18   VCCIO5   POWER
P19   GND   GND
P20   data_serial[15]   cmos33_rin_p
P21   sc_trstb_hybride[13]  cmos33_rdio_d2_ms3
P22   sc_tck_hybride[12]   cmos33_rdio_d2_ms3
R1   ladder_addr[1]   cmos33_rdin_p
R2   ladder_to_rdo[2]   cmos33_rdio_d2_ms3
R3   GND   GND
R4   VCCIO2   POWER
R5   sc_tms_hybride[5]   cmos33_rdio_d2_ms3
R7   ladder_to_rdo[4]   cmos33_rdio_d2_ms3
R11   sc_tdi_hybride[15]   cmos33_cio_d2_ms2
R12   sc_tdo_hybride[12]   cmos33_cin_p
R13   sc_tdo_hybride[14]   cmos33_cin_p
R14   sc_tck_hybride[11]   cmos33_cio_d2_ms2
R15   sc_trstb_hybride[10]  cmos33_cio_d2_ms2
R16   sc_trstb_hybride[7]   cmos33_cio_d2_ms2
R17   sc_tdi_hybride[13]   cmos33_rio_d2_ms5
R19   latchup_hybride[1]   cmos33_rdin_p
R21   tokenout_hybride[13]  cmos33_rdin_p
R22   data_serial[6]   cmos33_rdin_p
T1   rdo_to_ladder[18]   cmos33_rdin_p
T2   ladder_fpga_sc_tck   cmos33_rdin_p
T4   usb_read_n   cmos33_rio_d2_ms5
T6   VCCA1   POWER
T8   usb_data[3]   cmos33_cin_p
T9   sc_tms_hybride[0]   cmos33_cio_d2_ms2
T10   level_shifter_dac_sc  cmos33_cio_d2_ms2
T11   sc_tck_hybride[15]   cmos33_cio_d2_ms2
T12   sc_tms_hybride[14]   cmos33_cio_d2_ms2
T13   VCCINT   POWER
T15   latchup_hybride[0]   cmos33_cin_p
T17   roboclock_adc_phase[  cmos33_rio_d2p_ms6
T19   VCCIO5   POWER
T20   GND   GND
T21   sc_tdo_hybride[6]   cmos33_rdin_p
U1   ladder_to_rdo[1]   cmos33_rdio_d2_ms3
U2   ladder_addr[2]   cmos33_rdin_p
U3   GND   GND
U4   VCCIO2   POWER
U5   NC   NC
U6   VCCD_PLL1   POWER
U7   latchup_hybride[8]   cmos33_cin_p
U9   level_shifter_dac_ld  cmos33_cio_d2_ms2
U11   mux_ref_latchup[0]   cmos33_cio_d2_ms2
U12   sc_tdo_hybride[15]   cmos33_cin_p
U13   sc_trstb_hybride[5]   cmos33_cio_d2_ms2
U14   rdo_to_ladder[20]   cmos33_cin_p
U15   roboclock_adc_phase[  cmos33_cio_d2p_ms1
U16   VCCINT   POWER
U17   VCCINT   POWER
U18   VCCA4   POWER
U20   tokenout_hybride[11]  cmos33_rdin_p
U21   pilotage_mvdd_hybrid  cmos33_rdio_d2p_ms4
U22   pilotage_mvdd_hybrid  cmos33_rdio_d2p_ms4
V1   card_ser_num[5]   cmos33_rdin_p
V2   des_lock   cmos33_rdin_p
V5   rdo_to_ladder[19]   cmos33_cin_p
V7   dbg_ladder_fpga_adc_  cmos33_cio_d2_ms2
V8   holdin_echelle   cmos33_cin_p
V9   level_shifter_dac_sd  cmos33_cio_d2_ms2
V11   data_serial[13]   cmos33_cin_p
V12   data_serial[5]   cmos33_cin_p
V13   latchup_hybride[11]   cmos33_cin_p
V14   sc_tdo_hybride[11]   cmos33_cin_p
V15   roboclock_adc_phase[  cmos33_cio_d2p_ms1
V16   rdo_to_ladder[11]   cmos33_cin_p
V17   VCCD_PLL4   POWER
V18   NC   NC
V19   VCCIO5   POWER
V20   GND   GND
V21   pilotage_mvdd_hybrid  cmos33_rdio_d2p_ms4
V22   pilotage_magnd_hybri  cmos33_rdio_d2p_ms4
W1   fibre_mod_absent   cmos33_rdin_p
W2   des_bist_pass   cmos33_rdin_p
W3   GND   GND
W4   VCCIO2   POWER
W5   VCCIO3   POWER
W7   dbg_ladder_fpga_adc_  cmos33_cio_d2_ms2
W8   dbg_ladder_fpga_adc_  cmos33_cio_d2_ms2
W9   VCCIO3   POWER
W10   sc_tms_hybride[12]   cmos33_cio_d2_ms2
W11   VCCIO3   POWER
W12   VCCIO4   POWER
W13   ladder_to_rdo[7]   cmos33_cio_d2_ms2
W15   roboclock_adc_phase[  cmos33_cio_d2p_ms1
W16   VCCIO4   POWER
W17   sc_tms_hybride[13]   cmos33_cio_d2_ms2
W18   VCCIO4   POWER
W19   latchup_hybride[3]   cmos33_rdin_p
W20   sc_trstb_hybride[4]   cmos33_rdio_d2_ms3
W21   latchup_hybride[15]   cmos33_rdin_p
W22   latchup_hybride[12]   cmos33_rdin_p
Y1   fibre_tx_disable   cmos33_rdio_d2_ms3
Y2   usb_present   cmos33_rdin_p
Y5   GND   GND
Y6   usb_data[6]   cmos33_cin_p
Y7   ladder_fpga_sc_tdi   cmos33_cin_p
Y8   dbg_ladder_fpga_adc_  cmos33_cio_d2_ms2
Y9   GND   GND
Y10   ladder_to_rdo[12]   cmos33_cio_d2_ms2
Y11   GND   GND
Y12   GND   GND
Y13   sc_tck_hybride[14]   cmos33_cio_d2_ms2
Y14   VCCIO4   POWER
Y15   GND   GND
Y16   GND   GND
Y17   tokenout_hybride[12]  cmos33_cin_p
Y18   GND   GND
Y19   VCCIO5   POWER
Y20   GND   GND
Y21   latchup_hybride[14]   cmos33_rdin_p
Y22   pilotage_mvdd_hybrid  cmos33_rdio_d2p_ms4
[Model Selector] cmos33_cio_d2p_ms1
| 3.3-V LVCMOS, Column I/O
cmos33_cio_d2p   2mA, PCI
cmos33_cio_d2   2mA
[Model Selector] cmos33_cio_d2_ms2
| 3.3-V LVCMOS, Column I/O
cmos33_cio_d2   2mA
cmos33_cio_d2p   2mA, PCI
[Model Selector] cmos33_rdio_d2_ms3
| 3.3-V LVCMOS, Row I/O
cmos33_rdio_d2   2mA
cmos33_rdio_d2p   2mA, PCI
[Model Selector] cmos33_rdio_d2p_ms4
| 3.3-V LVCMOS, Row I/O
cmos33_rdio_d2p   2mA, PCI
cmos33_rdio_d2   2mA
[Model Selector] cmos33_rio_d2_ms5
| 3.3-V LVCMOS, Row I/O
cmos33_rio_d2   2mA
cmos33_rio_d2p   2mA, PCI
[Model Selector] cmos33_rio_d2p_ms6
| 3.3-V LVCMOS, Row I/O
cmos33_rio_d2p   2mA, PCI
cmos33_rio_d2   2mA
| Models and submodels in the file (18): cmos33_cin_p (Input), cmos33_cio_d2 (I/O), cmos33_cio_d2p (I/O), cmos33_rdio_d2p (I/O), cmos33_rdio_d2 (I/O), cmos33_rdin_p (Input), 3p3_rio_asdo_data1 (I/O), 3p3_ro_flsh_nce_ncso (I/O), cmos33_rio_d2p (I/O), cmos33_rio_d2 (I/O), 3p3_rio_data0 (I/O), 3p3_rio_dclk (I/O), ttl33_rin (Input), 3p3_rio_nstatus (I/O_open_drain), 3p3_ro_nceo (Output), 3p3_ro_tdo (Output), cmos33_rin_p (Input), 3p3_rio_condone (I/O_open_drain)
